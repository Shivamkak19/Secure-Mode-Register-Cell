ADE simulation setup
Run mode: Single Run, Sweeps and Corners
Tests:
  sec_reg_lib_NORM_REG_16B_tb_1: sec_reg_lib/NORM_REG_16B_tb/schematic, simulator spectre
