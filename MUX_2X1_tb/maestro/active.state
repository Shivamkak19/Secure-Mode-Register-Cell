ADE simulation setup
Test sec_reg_lib_MUX_2X1_tb_1: sec_reg_lib/MUX_2X1_tb/schematic, simulator spectre
  Models: /home/nverma/Public/cadence_23.1/gpdk045_v_6_0/gpdk045/../models/spectre/gpdk045.scs[mc]
  Temperature: 27
  Analysis tran: stop=160n
  Signals: /SEL, /SEL_BAR, /INP_0, /INP_1, /OUT
Run mode: Single Run, Sweeps and Corners
