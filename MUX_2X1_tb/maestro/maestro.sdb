ADE simulation setup
Run mode: Single Run, Sweeps and Corners
Tests:
  sec_reg_lib_MUX_2X1_tb_1: sec_reg_lib/MUX_2X1_tb/schematic, simulator spectre
