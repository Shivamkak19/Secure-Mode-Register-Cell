ADE simulation setup
Run mode: Single Run, Sweeps and Corners
Tests:
  sec_reg_lib_SEC_REG_1B_tb_1: sec_reg_lib/SEC_REG_1B_tb/schematic, simulator spectre
