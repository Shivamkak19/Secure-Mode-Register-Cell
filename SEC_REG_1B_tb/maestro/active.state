ADE simulation setup
Test sec_reg_lib_SEC_REG_1B_tb_1: sec_reg_lib/SEC_REG_1B_tb/schematic, simulator spectre
  Models: /home/nverma/Public/cadence_23.1/gpdk045_v_6_0/gpdk045/../models/spectre/gpdk045.scs[mc]
  Temperature: 27
  Analysis tran: stop=640n
  Signals: /SEC, /WE, /CLK, /Data, /Q_PUB, /Q_SEC
Run mode: Single Run, Sweeps and Corners
