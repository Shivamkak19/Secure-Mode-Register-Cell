ADE simulation setup
Run mode: Single Run, Sweeps and Corners
Tests:
  sec_reg_lib_INVX1_tb_1: sec_reg_lib/INVX1_tb/schematic, simulator spectre
