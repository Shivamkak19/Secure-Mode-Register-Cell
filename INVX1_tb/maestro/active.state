ADE simulation setup
Test sec_reg_lib_INVX1_tb_1: sec_reg_lib/INVX1_tb/schematic, simulator spectre
  Models: /home/nverma/Public/cadence_23.1/gpdk045_v_6_0/gpdk045/../models/spectre/gpdk045.scs[mc]
  Temperature: 27
  Analysis tran: stop=160n
  Signals: /A, /OUT
Run mode: Single Run, Sweeps and Corners
