ADE simulation setup
Run mode: Single Run, Sweeps and Corners
Tests:
  ece462_SEC_REG_16B_tb_1: ece462/SEC_REG_16B_tb/schematic, simulator spectre
