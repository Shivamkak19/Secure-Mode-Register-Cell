ADE simulation setup
Test ece462_SEC_REG_16B_tb_1: ece462/SEC_REG_16B_tb/schematic, simulator spectre
  Models: /home/nverma/Public/cadence_23.1/gpdk045_v_6_0/gpdk045/../models/spectre/gpdk045.scs[mc]
  Temperature: 27
  Analysis tran: stop=640n
  Signals: /SEC, /WE, /CLK, /net2, /Q_PUB<15:0>, /Q_SEC<15:0>
Run mode: Single Run, Sweeps and Corners
