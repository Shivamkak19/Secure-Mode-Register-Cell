ADE simulation setup
Test sec_reg_lib_POS_EDGE_REG_tb_1: sec_reg_lib/POS_EDGE_REG_tb/schematic, simulator spectre
  Models: /home/nverma/Public/cadence_23.1/gpdk045_v_6_0/gpdk045/../models/spectre/gpdk045.scs[mc]
  Temperature: 27
  Analysis tran: stop=160n
  Signals: /CLK, /D, /OUT
Run mode: Single Run, Sweeps and Corners
