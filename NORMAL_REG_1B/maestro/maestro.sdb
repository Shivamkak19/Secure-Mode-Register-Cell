ADE simulation setup
Run mode: Single Run, Sweeps and Corners
Tests:
  sec_reg_lib_Test_1: sec_reg_lib/Test/schematic, simulator spectre
