ADE simulation setup
Run mode: Single Run, Sweeps and Corners
Tests:
  sec_reg_lib_NAND_tb_1: sec_reg_lib/NAND_tb/schematic, simulator spectre
