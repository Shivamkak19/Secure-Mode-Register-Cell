ADE simulation setup
Test sec_reg_lib_NAND_tb_1: sec_reg_lib/NAND_tb/schematic, simulator spectre
  Models: /home/nverma/Public/cadence_23.1/gpdk045_v_6_0/gpdk045/../models/spectre/gpdk045.scs[mc]
  Temperature: 27
  Analysis tran: stop=160n
  Signals: /A, /B, /OUT
Run mode: Single Run, Sweeps and Corners
