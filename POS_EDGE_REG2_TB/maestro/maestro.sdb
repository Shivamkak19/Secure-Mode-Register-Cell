ADE simulation setup
Run mode: Single Run, Sweeps and Corners
Tests:
  sec_reg_lib_POS_EDGE_REG2_TB_1: sec_reg_lib/POS_EDGE_REG2_TB/schematic, simulator spectre
